V1 N001 0 5
R1 N002 N001 1000
R2 N003 N002 10
R3 N004 N003 10
R4 0 N004 34
R5 N002 0 1000
