* RC Low-Pass Filter
* Cutoff frequency: ~1.59kHz (R=10k, C=10n)
* f_c = 1 / (2 * pi * R * C)

V1 in 0 AC 1
R1 in out 10k
C1 out 0 10n

.ac dec 100 1 1Meg
.end
